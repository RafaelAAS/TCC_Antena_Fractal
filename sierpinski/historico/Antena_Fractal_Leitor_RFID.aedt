# Ansys Electronics Desktop project, version 2025.2
materials:
  vacuum: permittivity=1
  FR4_epoxy: permittivity=4.4 dielectric_loss_tangent=0.02

design Iteracao_0 (HFSS, HFSS Hybrid Modal Network, model units mm)
variables:
  W_sub = 60mm
  L_sub = 80mm
  h = 1.6mm
geometry:
  Substrato [FR4_epoxy] = box(corner=(-W_sub/2, -L_sub/2, 0mm), size=(W_sub, L_sub, h))
